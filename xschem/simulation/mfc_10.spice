** sch_path: /home/ttuser/Mfcs/mfc_10/xschem/mfc_10.sch
.subckt mfc_10 gate sbd
*.PININFO gate:I sbd:O
XM2 sbd gate sbd sbd sky130_fd_pr__nfet_01v8 L=0.3 W=0.42 nf=1 m=1
.ends
.end
